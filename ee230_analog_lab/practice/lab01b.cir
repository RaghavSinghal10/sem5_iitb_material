Expt1 RC differentiator
.include all_model_files/Diode_1N914.txt

* describe circuit
* <element name> <nodes list> <value>
* voltage_nodename positive_node negative_node dc_value/function
    * v 1 0 5
* sine voltage: sin(offset amplitude frequency time_delay damping_factor)
    * v 1 0 sin(0 2 1k 0 0)
* peicewise linear: pwl(time1 value1 time2 value2 ...)
    * v 1 0 pwl(0 0 10m 0 11m 5 20m 5)
* pulse waveform: pulse(initial-value pulsed-value delay_time rise_time fall_time pulse_width period)
    * v 1 0 pulse(0 1 1m 1m 1m 6m 10m)
* exponentioal waveform: exp(initial pulsed rise-delay rise-time fall-delay fall-time)
    * v 1 0 exp(1 0 10m 10m 10m 10m)
* ac analysis: dc dc_val ac ac_val
    * v 1 0 dc 0 ac 1
c0 1 2 0.1u
r0 2 0 10k
* vary PW and period
* tau = 1m
* factor is 10/5/1/0.1/0.05
v0 1 0 pulse(0 5 0 0 0 0.05m 0.1m)

* dc analysis: dc node_name initial_value final_value step
    * .dc v 0 5 0.1
* transient analysis: tran timestep end_time
    * .tran 10u 20m
* ac analysis: ac lin/dec num_points start_freq end_freq
    * .ac dec 10 1 1k
.tran 1u 5m

* start control
.control

run

* plot vdb(2); plots magnitude in dB
* plot phase(v(2)); plots phase of v(2)
* plot i(v); plots current through voltage_element v, only voltage elements allowed
* plot v(1) vs v(2); for output vs input
* use dummy voltage elements to measure current through all elements
plot v(2) v(1)

* hardcopy filename.ps plotting_value

* end control
.endc

.end
